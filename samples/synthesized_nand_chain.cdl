* 合成 8 段 NAND 链（用于自检；与论文 Table 1 场景一致）
* C0 = 0.74 fF, R0 = 8800 Ω, 0.1mm 线 (Cw=15fF, Rw=100Ω)
.SUBCKT nand_chain in out vdd gnd
* 输入端
R0 in net1 100
C0 net1 0 0.74f
* 段 1
R1 net1 net2 100
C1 net2 0 5.0f
* 段 2
R2 net2 net3 100
C2 net3 0 12.0f
* 段 3
R3 net3 net4 100
C3 net4 0 17.0f
* 段 4
R4 net4 net5 100
C4 net5 0 18.0f
* 段 5
R5 net5 net6 100
C5 net6 0 19.0f
* 段 6
R6 net6 net7 100
C6 net7 0 19.0f
* 段 7
R7 net7 net8 100
C7 net8 0 20.0f
* 段 8
R8 net8 out 100
C8 out 0 7.4f
.ENDS
