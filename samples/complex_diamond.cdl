* =====================================================================
*  complex_diamond.cdl
*  复杂菱形测试网表，用于 path_extract / verify 回路测试。
*
*  设计目标：
*    - 3 层嵌套菱形 (diamond L1 -> diamond L2 -> diamond L3)
*    - 含一个自环：A->B->A (BFS 应能自然去重，不死循环)
*    - 条件分支 sel_0 / sel_1 分别驱动独立子路径
*    - 所有 X 的 model 都在 .SUBCKT 中定义
*    - XInstance >= 30, net >= 40
*    - BFS 从 "in" 到 "out" 必然可达
*
*  端口约定（启发式合规）：
*    XInstance 的 nets 列表中，最后一个 net 视为输出，其余视为输入。
*    因此每个 X 调用把功能信号 net 放在 nets 列表中，vdd/gnd 通过
*    .GLOBAL 在符号级隐式连入，不出现在 X nets 里。
* =====================================================================

.GLOBAL vdd gnd

* ---------------------------------------------------------------------
* Placeholder subckts（占位，仅供 netlist 定义存在性；内部无器件）
* ---------------------------------------------------------------------
.SUBCKT INV A Z vdd gnd
.ENDS
.SUBCKT NAND2 A B Z vdd gnd
.ENDS
.SUBCKT AOI21 A B C Z vdd gnd
.ENDS
.SUBCKT BUF A Z vdd gnd
.ENDS
.SUBCKT DFF_in D Q vdd gnd
.ENDS
.SUBCKT mux2 sel A B Z vdd gnd
.ENDS
.SUBCKT sram_cell WL BL BLB vdd gnd
.ENDS

* ---------------------------------------------------------------------
* 顶层：sram_path
*   in -> Stage0 buffer -> L1 菱形
*       -> L2 菱形（含自环）
*       -> L3 菱形
*       -> 末端 AOI + NAND -> drv_out -> BUF -> out
*   sel_0 / sel_1 命名上分别控制不同子路径（条件分支）
* ---------------------------------------------------------------------
.SUBCKT sram_path in sel out vdd gnd

* ----- Stage 0: 输入缓冲 + sram_cell 占位 -----
XST0_BUF in        n_entry BUF
XST0_CAP n_entry              sram_cell

* ====== L1 菱形 (sel_0 控制主路径) ======
* L1 mux: sel=sel_0, A=in, B=alt_in → sel_0_mux_out
XL1_M0 sel_0 in alt_in         sel_0_mux_out mux2
* L1 left branch: NAND链
XL1_L0 sel_0_mux_out           n_l1a1 NAND2
XL1_L1 n_l1a1 sel_0            n_l1a2 NAND2
* L1 right branch: INV→NAND
XL1_R0 sel_0_mux_out           n_l1b1 INV
XL1_R1 n_l1b1 sel_0            n_l1b2 NAND2
* L1 sub-branch: sel_1 控制并行路径
XL1_P0 sel_1 n_l1a1 alt_in_p   n_l1p_out mux2
XL1_P1 n_l1p_out n_l1b1 sel_1  n_l1q_out mux2

* ====== L2 菱形 (sel_1 控制主路径; 含自环) ======
XL2_M0 sel_1 n_l1a2 n_l1b2     n_l2_mid mux2
XL2_L0 n_l2_mid sel_0 vdd      n_l2a1 AOI21
XL2_L1 n_l2a1 sel_1 vdd        n_l2a2 AOI21
XL2_R0 n_l2_mid n_l1a2 vdd     n_l2b1 NAND2
XL2_R1 n_l2b1 n_l1b2 sel_0     n_l2b2 NAND2

* --- 自环节点：feed-back 环 A->B->A (BFS visited 应去重) ---
* A = n_l2a2, B = n_back, 再回 A = n_l2a2b -> n_l2a2
XL2_FB0 sel_0 n_l2a2           n_back_a NAND2
XL2_FB1 vdd n_back_a n_l2b2    n_back_b NAND2
XL2_FB2 n_back_b vdd n_back_a  n_l2a2b AOI21
XL2_FB3 sel_1 n_l2a2b          n_back_c NAND2
XL2_FB4 n_l2a2 n_back_c n_l2b2 n_back_d NAND2
XL2_FB5 n_back_d sel_0 n_l2a2b n_l2a2b2 AOI21
XL2_FB2B n_l2a2b2 sel_1 vdd    n_l2a2 AOI21
XL2_FB3B n_l2a2 n_l2b2 vdd     n_l2b2_ AOI21

* --- DFF 占位 + 信号串联 (sel_1 / sel_0 通路) ---
XL2_D0 D_sel clk               DFF_in_in DFF_in
XL2_D1 DFF_in_in sel_0         Q_l2 NAND2
XL2_D2 Q_l2 sel_1              Q_l2_xor INV

* ====== L3 菱形 (顶层三分支汇聚) ======
XL3_M0 sel_0 Q_l2_xor n_l2a2   n_l3_mid mux2
XL3_L0 n_l3_mid sel_1 vdd      n_l3a1 NAND2
XL3_L1 n_l3a1 sel_0 sel_1      n_l3a2 NAND2
XL3_R0 n_l3_mid n_l2b2_ vdd    n_l3b1 NAND2
XL3_R1 n_l3b1 sel_1 sel_0      n_l3b2 NAND2
* L3 三分支交汇 + 旁路 (sel_0 通道)
XL3_MID n_l3a2 vdd n_l3b2      n_l3_mid2 AOI21
XL3_MIX n_l3_mid2 sel_0 sel_1  n_l3_mix NAND2
XL3_BP0 sel_0 Q_l2_xor n_l2a2b n_l3_bp1 mux2
XL3_BP1 sel_1 n_l3_bp1 alt_p   n_l3_bp2 mux2
XL3_BP2 n_l3_bp2 vdd n_l2b2_   n_l3_bp3 NAND2
XL3_BP3 n_l3_bp3 sel_0 sel_1   n_l3_bp4 NAND2

* ----- 末端驱动 & 输出 buffer -----
XEND_AOI n_l3_mix sel_1 vdd    pre_out AOI21
XEND_NAND pre_out sel_0 sel_1  drv_out NAND2
XEND_BUF drv_out               o_local BUF
XEND_CAP o_local               sram_cell
XOUT_BUF o_local               out BUF

.ENDS
